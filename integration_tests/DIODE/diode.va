`include "constants.vams"
`include "disciplines.vams"

`define OPVARS

module diode_va(A,C,dT);
    // simple diode with self-heating network
    inout A, C, dT;
    electrical A,C,CI,dT;

    branch (A,CI) br_a_ci;
    branch (CI,C) br_ci_c;
    branch (dT )  br_sht; //self-heating

    (*desc= "Saturation current", units = "A"*) parameter real Is = 1e-14 from [0:inf];

    (*desc= "Ohmic res", units = "Ohm" *) parameter real Rs = 0.0 from [0:inf];

    (*desc= "Temperature coefficient of ohmic res"*) parameter real zetars = 0.0 from [-10:10];

    (*desc= "Emission coefficient"*) parameter real N = 1.0 from [0:inf];

    (*desc= "Junction capacitance", units = "F"*) parameter real Cj0 = 0.0 from [0:inf];

    (*desc= "Junction potential", units = "V"*) parameter real Vj = 1.0 from [0.2:2];

    (*desc= "Grading coefficient"*) parameter real M = 0.5 from [0:inf];

    (*desc= "Thermal resistance", units = "K/W"*) parameter real Rth = 0 from [0:inf];

    (*desc= "Temperature coefficient of thermal res"*) parameter real zetarth = 0.0 from [-10:10];

    (*desc= "Temperature coefficient of Is"*) parameter real zetais = 3.0 from [-10:10];
    (*desc= "Acitvation Energy", units = "eV"*) parameter real ea = 1.11 from [-10:10];

    (*desc= "Reference temperature", units = "Kelvin"*) parameter real Tnom = 300 from [0:inf];

    (*desc="minr is the value below which the simulator expects elimination of resitance and it will improve simulation efficiency without significantly altering the results.", units ="Ohm"*) parameter real minr = $simparam("minr", 1m) from (0:inf);

    real Vd, Vd_smooth, Vr, Id, Qd, Ist;

`ifdef OPVARS
    (*desc = "diode junction capcitance", units="F"*) real cd;
    (*desc = "diode admittance", units="S"*) real gd;
`endif

    real VT,x,y,vf,Tdev,pterm,rs_t, rth_t, Is_t;

    analog begin

        if (Rth > minr) begin
            Tdev = $temperature+V(br_sht);
        end else begin
            Tdev = $temperature;
        end
        VT = `P_K*Tdev/`P_Q;

        Is_t = Is * exp(ln(Tdev/Tnom)*zetais/N + ((Tdev / Tnom) - 1) * ea / (VT * N));
        rs_t = Rs*pow(Tdev/Tnom,zetars);
        rth_t = Rth*pow(Tdev/Tnom,zetarth);

        Vd = V(br_a_ci);
        Vr = V(br_ci_c);
        Id =  Is_t * (limexp(Vd / (N * VT)) - 1);

        //junction capacitance
        //smoothing of voltage over cap
        vf   = Vj*(1 - pow(3.0, -1/M));
        x    = (vf-Vd)/VT;
        y    = sqrt(x*x + 1.92);
        Vd_smooth   = vf-VT*(x + y)/(2);
        Qd   = Cj0*Vj * (1-pow(1-Vd_smooth/Vj, 1-M))/(1-M);

        I(br_a_ci) <+ Id + ddt(Qd) + $simparam("gmin", 1e-12) * Vd;

        if (Rs > minr) begin
            I(br_ci_c) <+ Vr / rs_t;
        end else begin
            V(br_ci_c) <+ 0.0;
        end

        if (Rth > minr) begin
            // dissipated power
            pterm = Id*Vd;
            if (Rs > minr) begin
                pterm = pterm + pow(Vr,2.0)/rs_t;
            end

            I(br_sht)  <+ pterm - V(br_sht)/rth_t;
        end else begin
            V(br_sht) <+ 0;
        end

`ifdef OPVARS
        cd   = ddx(Qd,V(A));
        gd   = ddx(Id,V(A));
`endif
    end
endmodule
