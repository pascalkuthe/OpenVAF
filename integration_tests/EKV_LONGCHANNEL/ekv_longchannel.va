/*
EKV MOS model version 2.6 rev.15 with documentation at: http://ekv.epfl.ch
Matthias Bucher, Christophe Lallement, Christian Enz, Fabien Theodoloz, Francois Krummenacher
Electronics Laboratories, Swiss Federal Institute of Technology Lausanne, Switzerland
This Verilog-A was developed by Wladek Grabinski with modifications
by Tiburon Design Automation (www.tiburon-da.com).
This software has been provided pursuant to a License Agreement containing restrictions on its use.
It may not be copied or distributed in any form or medium, disclosed to third parties,
reverse engineered or used in any manner not provided for in said License Agreement
except with the prior written authorization.
Licensed under the Educational Community License, Version 2.0 (the "License");
you may not use this file except in compliance with the License.

You may obtain a copy of the License at http://opensource.org/licenses/ECL-2.0

Unless required by applicable law or agreed to in writing, software distributed under
the License is distributed on an "AS IS" BASIS, WITHOUT WARRANTIES OR CONDITIONS OF ANY KIND,
either express or implied. See the License for the specific language governing permissions
and limitations under the License.

$RCSfile: ekv.va,v $ $Revision: 1.9 $    $Date: 2003/12/17 01:20:10 $
$RCSfile: ekv.va,v $ $Revision: 2.6.15 $ $Date: 2020/05/29 11:50:10 $
*/

`include "disciplines.va"
`include "constants.va"

// ****************************************************************
// * EKV MOS model (long channel) based on version 2.6 rev.15
// * Function name : ekv26_dc_long for verilog-a implementation
// * The model documetation: http://legwww.epfl.ch/ekv
// ****************************************************************

module ekv(d,g,s,b);
//
// Node definitions
//
inout           d,g,s,b ;   // external nodes
electrical      d,g,s,b ;   // external nodes
//
//*** Local variables
//
real x, VG, VS, VD, VGprime, VP;
real beta, n, iff, ir, Ispec, Id;
real arg;
//
//*** model parameter definitions
//
parameter real L      =  10E-6  from[0.0:inf];
parameter real W      =  10E-6  from[0.0:inf];

//***  Threshold voltage
//     substrate effect parameters (long-channel)
parameter real VTO    =  0.5    from[0.0:inf];
parameter real GAMMA  =  0.7    from[0.0:inf];
parameter real PHI    =  0.5    from[0.2:inf];

//***  Mobility parameters (long-channel)
parameter real KP     =  20E-6   from[0.0:inf];
parameter real THETA  =  50.0E-3 from[0.0:inf];

analog begin // EKV v2.6 long-channel

VG = V(g, b); VS = V(s, b); VD = V(d, b);

// Effective gate voltage (33)
VGprime = VG - VTO + PHI + GAMMA * sqrt(PHI);

// Pinch-off voltage (34)
if (VGprime+(GAMMA/2.0)*(GAMMA/2.0) > 1e-12) begin
    VP = VGprime - PHI - GAMMA
    * (sqrt(VGprime+(GAMMA/2.0)*(GAMMA/2.0))-(GAMMA/2.0));
end else begin
    VP = VGprime - PHI - GAMMA * GAMMA/2.0;
end

// Slope factor (39)
if ((PHI + VP + 4.0*$vt) > 1e-24 )
    n = 1.0 + GAMMA / (2.0*sqrt(PHI + VP + 4.0*$vt));
else
    n = 1.0 + GAMMA / 2 * 1e48;

// Mobility equation (58), (64)
beta = KP * (W/L) * (1.0/(1.0 + THETA * VP));

// forward (44) and reverse (56) currents
x=(VP-VS)/$vt; iff = (ln(1.0+exp( x /2.0)))*(ln(1.0+exp( x /2.0)));
x=(VP-VD)/$vt; ir  = (ln(1.0+exp( x /2.0)))*(ln(1.0+exp( x /2.0)));

// Specific current (65)
Ispec = 2 * n * beta * $vt * $vt;

// Drain current (66)
Id = Ispec * (iff - ir);

//
// Branch contributions to EKV v2.6 model (long-channel)
//
I(d,s) <+ Id;

end // analog
endmodule
