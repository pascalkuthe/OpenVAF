// ****************************************************************************
// *  BSIM-IMG 103.0.0 released by Pragya Kushwaha on 1/2/2020                *
// *  BSIM Independent Multi-Gate Model (Verilog-A)                           *
// ****************************************************************************

// ****************************************************************************
// *  Copyright © 2020 University of California                               *
// *                                                                          *
// *  Project director: Prof. Chenming Hu                                     *
// *                                                                          *
// *  Current developers: Pragya Kushwaha (Postdoc, UC Berkeley)              *
// *                      Harshit Agarwal (Postdoc, UC Berkeley)              *
// *                      Avirup Dasgupta (Postdoc, UC Berkeley)              *
// *                      Girish Pahwa    (Postdoc, UC Berkeley)              *
// *                      Chetan K. Dabhi (Ph.D., IIT Kanpur)                 *
// ****************************************************************************

/*
Licensed under Educational Community License, Version 2.0 (the "License"); you may
not use this file except in compliance with the License. You may obtain a copy of the license at
http://opensource.org/licenses/ECL-2.0
Unless required by applicable law or agreed to in writing, software distributed under the License is distributed on an "AS IS" BASIS, WITHOUT
WARRANTIES OR CONDITIONS OF ANY KIND, either express or implied. See the License for the specific language governing permissions and limitations
under the License.

BSIM-IMG model is supported by the members of Silicon Integration Initiative's Compact Model Coalition. A link to the most recent version of this
standard can be found at: http://www.si2.org/cmc
*/

`include "constants.vams"
`include "disciplines.vams"

// ************************************************************
// *  SHMOD is a model parameter                              *
// *    SHMOD = 1: Self-heating turned on                     *
// *    SHMOD = 0: Self-heating turned off                    *
// *                                                          *
// *  RDSMOD is a model parameter                             *
// *    RDSMOD = 1: External source/drain resistance model    *
// *    RDSMOD = 0: Internal source/drain resistance model    *
// *                                                          *
// *  RGATEMOD is a model parameter                           *
// *    RGATEMOD = 1: Gate Resistance / ge node turned on     *
// *    RGATEMOD = 0: Gate Resistance / ge node turned off    *
// ************************************************************

// In Verilog-A the number of internal nodes cannot be controlled
// by a model parameter. Therefore we use `define statements to
// control it. Comment the following lines whenever possible for
// best computational efficiency.

`include "common_defs.include"

module bsimimg(d, fg, s, bg, t);
inout d, fg, s, bg, t;
electrical d, fg, s, bg,di, si, ge, gi;
thermal t;
branch (t) rth_branch;
branch (t) ith_branch;

`include "bsimimg_body.include"

endmodule
