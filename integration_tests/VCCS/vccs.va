`include "constants.vams"
`include "disciplines.vams"

module vccs_va(Inp,Inm,Outp,Outm);
    // ideal voltage controlled current source
    inout Inp, Inm,Outp,Outm;
    electrical Inp, Inm,Outp,Outm;

    branch (Inp,Inm) br_in;
    branch (Outp,Outm) br_out;

    (*desc= "transconductance"*) parameter real G = 10 from [0:inf];
    (*desc= "input Resistance", units = "Ohm" *) parameter real Rin = 1e9 from [-inf:inf];
    (*desc= "output Resistance", units = "Ohm" *) parameter real Rout = 1e9 from [-inf:inf];

    real Vout,Vin;

    analog begin
        Vout = V(br_out);
        Vin = V(br_in);
        I(br_out) <+ Vin*G+Vout/Rout;
        I(br_in) <+ Vin/Rin;
    end
endmodule
