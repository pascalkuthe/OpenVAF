(*openvaf_allow="lint_not_found"*) module test();
        (*openvaf_allow="foo"*) parameter real bar=0.0;
endmodule

(*openvaf_warn="lint_not_found"*) module test();
        (*openvaf_allow="foo"*) parameter real bar=0.0;
endmodule

module test();
    (*openvaf_allow="foo",openvaf_allow="lint_not_found"*) parameter real bar=0.0;
endmodule
