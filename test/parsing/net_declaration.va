module test ();
    wire x,y;
    electrical z;
    wire electrical l;

endmodule
