// ****************************************************************************
// *  BSIM-IMG 102.9.1 released by Pragya Kushwaha on 11/21/2017              *
// *  BSIM Independent Multi-Gate Model (Verilog-A)                           *
// ****************************************************************************

// ****************************************************************************
// *  Copyright 2017 Regents of the University of California                  *
// *  All rights reserved.                                                    *
// *                                                                          *
// *  Project director: Prof. Chenming Hu                                     *
// *                                                                          *
// *  Current developers: Dr. Pragya Kushwaha (Postdoc, UC Berkeley)          *
// *                      Yen-Kai Lin (Ph.D. student, UC Berkeley)            *
// *                      Juan Duarte (Ph.D. student, UC Berkeley)            *
// *                      Dr. Harshit Agarwal (Postdoc, UC Berkeley)          *
// *                      Dr. Huan-Lin Chang (Postdoc, UC Berkeley)           *
// ****************************************************************************

// ****************************************************************************
// *  Software is distributed as is, completely without warranty or service   *
// *  support. The University of California and its employees are not liable  *
// *  for the condition or performance of the software.                       *
// *                                                                          *
// *  The University of California owns the copyright and grants users a      *
// *  perpetual, irrevocable, worldwide, non-exclusive, royalty-free license  *
// *  with respect to the software as set forth below.                        *
// *                                                                          *
// *  The University of California hereby disclaims all implied warranties.   *
// *                                                                          *
// *  The University of California grants the users the right to modify,      *
// *  copy, and redistribute the software and documentation, both within      *
// *  the user's organization and externally, subject to the following        *
// *  restrictions:                                                           *
// *                                                                          *
// *  1. The users agree not to charge for the University of California code  *
// *     itself but may charge for additions, extensions, or support.         *
// *                                                                          *
// *  2. In any product based on the software, the users agree to             *
// *     acknowledge the University of California that developed the          *
// *     software. This acknowledgment shall appear in the product            *
// *     documentation.                                                       *
// *                                                                          *
// *  3. Redistributions to others of source code and documentation must      *
// *     retain the copyright notice, disclaimer, and list of conditions.     *
// *                                                                          *
// *  4. Redistributions to others in binary form must reproduce the          *
// *     copyright notice, disclaimer, and list of conditions in the          *
// *     documentation and/or other materials provided with the               *
// *     distribution.                                                        *
// *                                                                          *
// *  Agreed to on _________Nov. 21, 2017__________                           *
// *                                                                          *
// *  By: ____University of California, Berkeley___                           *
// *      ____Chenming Hu__________________________                           *
// *      ____Professor in Graduate School ________                           *
// ****************************************************************************

`include "constants.vams"
`include "disciplines.vams"

// ****************************************************************************
// *  SHMOD is a model parameter                                              *
// *  - SHMOD = 0: Self-heating turned off                                    *
// *  - SHMOD = 1: Self-heating turned on                                     *
// *                                                                          *
// *  RDSMOD is a model parameter                                             *
// *  - RDSMOD = 0: Bias-dependent S/D resistances are internal and           *
// *                bias-independent S/D resistances are external             *
// *  - RDSMOD = 1: Both bias-dependent and independent of S/D resistances    *
// *                are external                                              *
// *  - RDSMOD = 2: Both bias-dependent and independent of S/D resistances    *
// *                are internal                                              *
// *                                                                          *
// *  RGATEMOD is a model parameter                                           *
// *  - RGATEMOD = 0: Gate resistance / ge node turned off                    *
// *  - RGATEMOD = 1: Gate resistance / ge node turned on                     *
// ****************************************************************************

// In Verilog-A the number of internal nodes cannot be controlled by a model
// parameter. Therefore we use `define statements to control it. Comment the
// following lines whenever possible for best computational efficiency.

`define VGFB2N  -1.2

`include "common_defs.include"
`include "bsimimg_sp.include"

module bsimimg(d, fg, s, bg, t);
    inout d, fg, s, bg, t;
    electrical d, fg, s, bg, di, si, gi, ge;
    thermal t;
    branch (t) rth_branch;
    branch (t) ith_branch;

`include "bsimimg_body.include"

endmodule
