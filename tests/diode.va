`include "constants.va"
module Diode(inout electrical A,inout electrical C);
  branch (A,C) d;
  (*unit=A*) parameter real I_s0 = 1E-11 from [1E-20:1];
  parameter real m = 1 from [0.1:10];
  parameter real zeta = 1;
  (*unit=K*) parameter real T_0 = 300 from [0:inf];
  real V_t,I_s;
  (*extract, unit=A *) real I_d;
  analog begin
        I_s = I_s0*(T/T_0)**zeta;
        V_t = `P_K*$temperature/`P_Q;
        I_d = I_s * exp( V(d) /(m*V_t) );
        I(d) <+ I_d;
   end
endmodule
