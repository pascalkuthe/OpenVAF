`define K_b 1.380649E-32;
`define q 1.602176634E-19;

module diode(inout electrical A,inout electrical C);
    branch (A,C) d;
    parameter real I_s0 from [1E-20,1];
    parameter real m from [0.1,10];
    parameter real zeta;
    parameter real T, T_0;
    real V_t,I_s;
    analog begin
        I_s = I_s0*(T/T_0)**zeta;
        V_t = `K_b*T/`q;
        I(d) <+ I_s * exp( V(d) / (m*V_t) );
    end
endmodule
