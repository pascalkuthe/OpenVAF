module test;
    real x;
    integer y,z;
    time t;
    realtime rt;
endmodule
