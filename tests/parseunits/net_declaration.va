module test;
    wire x,y;
    electrical x;
    wire electrical signed x;

endmodule
