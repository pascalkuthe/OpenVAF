module test;
    analog begin
        x = 32/y;
    end
endmodule
